module OLTC(vp,vq,tap);
input vp,vq;
output tap;

electrical vp,vq;
electrical tap;

parameter real    TAP  = 1.0;
parameter real    BAND = 0.05*2; // +/- 5% amplitude of the regulation band.
parameter real    TW   = 30;
parameter real    TC   = 1u;
parameter real    STEP = BAND/(33*2);
parameter integer OFF  = 0; // 'OFF=true' means that the ULTC is off.
parameter integer DBG  = 0;

real Vmag, TstartUp, TstartLow, Tap;
real Vup, Vlo;
integer Upper, Lower;

analog begin

    @( initial_model ) begin
	if( analysis("restart") ) begin
	    Tap   = TAP;
	    Upper = 0;
	    Lower = 0;
	    if( 0 != DBG )
		$display("Initial model\n");
	end
    end

    if( analysis( "dc" ) ) begin
	Vmag = max( 1k, sqrt( v(vp)*v(vp) + v(vq)*v(vq) ) );
	Vup   = (Tap+STEP) * Vmag;
	Vlo   = (Tap-STEP) * Vmag;
    end
    else if( analysis( "tran" ) )
	Vmag = max( 1k, sqrt( v(vp)*v(vp) + v(vq)*v(vq) ) );

    @( initial_step ) begin
	if( analysis("restart") ) begin
	    Tap   = TAP;
	    Upper = 0;
	    Lower = 0;

	    Vup   = (Tap+STEP) * Vmag;
	    Vlo   = (Tap-STEP) * Vmag;
	end

	if( 0 != DBG )
	    $display("Initial step -- Tap %e\n", Tap);
    end

    if( analysis( "tran" ) ) begin
	if( OFF == 0 ) begin
	    if( Upper == 0 )
		@( above( Vmag - Vup*(1+1m), TC ) ) begin
		    TstartUp = $abstime;
		    Upper  = 1;
		    if( 0 != DBG )
			$display( "Up %d -- time %e\n", Upper, $abstime );
		end

	    if( Upper == 1 )
		@( above( Vup*(1-1m) - Vmag, TC ) ) begin
		    Upper = 0;
		    if( 0 != DBG )
			$display( "Up %d -- time %e\n", Upper, $abstime );
		end

	    if( Lower == 0 )
		@( above( Vlo*(1-1m) - Vmag, TC ) ) begin
		    TstartLow = $abstime;
		    Lower  = 1;
		    if( 0 != DBG )
			$display( "Lw %d -- time %e\n", Lower, $abstime );
		end

	    if( Lower == 1 )
		@( above( Vmag - Vlo*(1+1m), TC ) ) begin
		    Lower = 0;
		    if( 0 != DBG )
			$display( "Lw %d -- time %e\n", Lower, $abstime );
		end

	    if( Upper == 1 ) begin
		if( $abstime > TstartUp + TW ) begin
		    if( Vmag > Vup ) begin
			Tap = Tap + STEP;
			if( 0 != DBG )
			    $display( "UpTap %d -- time %e\n", Tap, $abstime );
		    end

		    TstartUp = $abstime;

		end
	    end

	    if( Lower == 1 ) begin
		if( $abstime > TstartLow + TW ) begin
		    if( Vmag < Vlo ) begin
			Tap = Tap - STEP;
			if( 0 != DBG )
			    $display( "DwTap %d -- time %e\n", Tap, $abstime );
		    end

		    TstartLow = $abstime;
		end
	    end
	end
    end

    v(tap) <+ transition( Tap, 0, 100m, 100m );

end

endmodule
